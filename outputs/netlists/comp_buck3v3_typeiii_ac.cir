* Type III compensation network, +3V3 rail. AC response of Zf/Zi.
Vac   out 0 AC 1
R1    out fb  10200
Rbot  fb  0   3240
R3    out n3  115
Cf3   n3  fb  1.3e-09
Rf    comp nf 4530
Cf1   nf  fb  3.3e-09
Cf2   comp fb 7.5e-11
Eea   comp 0  0 fb 1e6
.ac dec 100 10 10Meg
.end
