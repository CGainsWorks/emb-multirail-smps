* Type II compensation network, +12V rail. AC response of Kdiv*gm*Z.
Vac   out 0 AC 1
Rtop  out fb  69800
Rbot  fb  0   4990
Gea   0 comp  fb 0 0.0006
Ro    comp 0  2e+07
Rc    comp nc 8200
Cc    nc   0  3.3e-08
Cp    comp 0  1e-10
.ac dec 100 1 10Meg
.end
