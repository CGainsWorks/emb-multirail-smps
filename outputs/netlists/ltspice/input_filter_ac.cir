* LTspice dialect. Open in LTspice, or run: LTspice -b <file>
* Generated by smps.spice. Do not edit; `make demo` overwrites it.
* NOT EXECUTED BY CI. No runner has an LTspice. See STATUS.md.
* Differential mode input filter into a 50 ohm / 5 uH LISN
Iconv conv 0 AC 1
C1    conv 0 9e-06 Rser=0.0015 Lser=1.2e-09
Cbulk conv 0 0.00022 Rser=0.015 Lser=6e-09
Ldm   conv lead 1e-05 Rser=0.04
C2    lead 0 2.2e-06 Rser=0.008 Lser=3e-09
Llisn lead lisn 5e-06
Rlisn lisn 0 50
.ac dec 25 10k 30meg
.end
