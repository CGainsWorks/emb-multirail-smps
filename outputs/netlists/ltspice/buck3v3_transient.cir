* LTspice dialect. Open in LTspice, or run: LTspice -b <file>
* Generated by smps.spice. Do not edit; `make demo` overwrites it.
* NOT EXECUTED BY CI. No runner has an LTspice. See STATUS.md.
* +3V3 synchronous buck, voltage mode, Type III compensation
Vin   vin 0 5
Rload out 0 1.1
Shs   vin sw   gate 0 swhs
Sls   sw  0    gateb 0 swls
Bgb   gateb 0 V=1-V(gate)
L1    sw  out 1.5e-06 Rser=0.015
Cout  out cx 3.3e-05
Resr  cx  0  0.001
Cin   vin 0  1.4e-05 Rser=0.0015
Vramp ramp 0 PULSE(0 1 0 9.8e-07 2e-08 1n 1e-06)
Bpwm  gate 0 V=IF(V(comp)>V(ramp),1,0)
R1    out fb 10200
Rbot  fb  0  3740
R3    out n3 115
Cf3   n3  fb 1.3e-09
Rf    comp nf 4420
Cf1   nf  fb 3.3e-09
Cf2   comp fb 7.5e-11
Bea   comp 0 V=LIMIT(0.891*1e5-V(fb)*1e5, 0, 1)
.model SWMOD SW(Ron=0.03 Roff=1Meg Vt=0.5 Vh=0)
.tran 1e-08 2m 1.5m 2e-08
.end
