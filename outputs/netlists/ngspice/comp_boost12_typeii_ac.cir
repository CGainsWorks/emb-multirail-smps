* Strict ngspice. Run: ngspice -b <file>
* Generated by smps.spice. Do not edit; `make demo` overwrites it.
* Type II compensation network, +12V rail
Vac   out 0 dc 0 ac 1
Rtop  out fb  69800
Rbot  fb  0   4990
Gea   0 comp  fb 0 0.0006
Ro    comp 0  2e+07
Rc    comp nc 8200
Cc    nc   0  3.3e-08
Cp    comp 0  1e-10
.control
ac dec 25 1 10meg
wrdata typeii_12v.dat v(comp)
quit
.endc
.end
