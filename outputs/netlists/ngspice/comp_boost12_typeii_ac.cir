* Strict ngspice. Run: ngspice -b <file>
* Generated by smps.spice. Do not edit; `make demo` overwrites it.
* Type II compensation network, +12V rail
Vac   out 0 dc 0 ac 1
Rtop  out fb  44200
Rbot  fb  0   4990
Gea   0 comp  fb 0 0.0011
Ro    comp 0  1e+07
Rc    comp nc 3000
Cc    nc   0  1e-07
Cp    comp 0  2.7e-10
.control
ac dec 25 1 10meg
wrdata typeii_12v.dat v(comp)
quit
.endc
.end
