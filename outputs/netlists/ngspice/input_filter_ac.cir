* Strict ngspice. Run: ngspice -b <file>
* Generated by smps.spice. Do not edit; `make demo` overwrites it.
* Differential mode input filter into a 50 ohm / 5 uH LISN
Iconv conv 0 dc 0 ac 1
C1    conv c1a 9e-06
L1esl c1a  c1b 1.2e-09
R1esr c1b  0   0.0015
Cb    conv cba 0.00022
Lbesl cba  cbb 6e-09
Rbesr cbb  0   0.015
Ldm   conv ldm 1e-05
Rdm   ldm  lead 0.04
C2    lead c2a 2.2e-06
L2esl c2a  c2b 3e-09
R2esr c2b  0   0.008
Llisn lead lisn 5e-06
Rlisn lisn 0   50
.control
ac dec 25 10k 30meg
wrdata input_filter.dat v(lisn)
quit
.endc
.end
