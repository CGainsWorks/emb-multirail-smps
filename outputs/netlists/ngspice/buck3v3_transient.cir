* Strict ngspice. Run: ngspice -b <file>
* Generated by smps.spice. Do not edit; `make demo` overwrites it.
* +3V3 synchronous buck, voltage mode, Type III compensation
Vin   vin 0 5
Rload out 0 1.1
Shs   vin sw   gate 0 swmod
Sls   sw  0    gateb 0 swmod
Bgb   gateb 0 V = 1 - V(gate)
L1    sw  lx 1.5e-06
Rl1   lx  out 0.015
Cout  out cx 3.3e-05
Resr  cx  0  0.001
Cin   vin ci 1.4e-05
Rcin  ci  0  0.0015
Vramp ramp 0 PULSE(0 1 0 9.8e-07 2e-08 1n 1e-06)
Bpwm  gate 0 V = V(comp) > V(ramp) ? 1 : 0
R1    out fb 10200
Rbot  fb  0  3240
R3    out n3 115
Cf3   n3  fb 1.3e-09
Rf    comp nf 4530
Cf1   nf  fb 3.3e-09
Cf2   comp fb 7.5e-11
Bea   comp 0 V = min(max(1e5 * (0.8 - V(fb)), 0), 1)
.model swmod sw(ron=0.03 roff=1meg vt=0.5 vh=0)
.control
tran 1e-08 2m 1.5m 2e-08
meas tran vavg AVG v(out) from=1.9m to=2m
meas tran vmax MAX v(out) from=1.9m to=2m
meas tran vmin MIN v(out) from=1.9m to=2m
quit
.endc
.end
