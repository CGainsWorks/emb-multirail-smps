* Strict ngspice. Run: ngspice -b <file>
* Generated by smps.spice. Do not edit; `make demo` overwrites it.
* +3V3 synchronous buck, voltage mode, Type III compensation
Vin   vin 0 5
Rload out 0 1.1
Shs   vin sw   gate 0 swhs
Sls   sw  0    gateb 0 swls
Bgb   gateb 0 V = 1 - V(gate)
L1    sw  lx 1.5e-06
Rl1   lx  out 0.015
Cout  out cx 3.3e-05
Resr  cx  0  0.001
Cin   vin ci 1.4e-05
Rcin  ci  0  0.0015
Vramp ramp 0 PULSE(0 1 0 9.8e-07 2e-08 1n 1e-06)
Bpwm  gate 0 V = min(max(0.5 + 1000*(V(comp) - V(ramp)), 0), 1)
R1    out fb 10200
Rbot  fb  0  3740
R3    out n3 115
Cf3   n3  fb 1.3e-09
Rf    comp nf 4420
Cf1   nf  fb 3.3e-09
Cf2   comp fb 7.5e-11
Bea   comp 0 V = min(max(1e5 * (0.891 - V(fb)), 0), 1)
* Separate models, because the two devices do not have the same Rds(on) and
* using one model for both was quietly putting the high side figure on the low
* side as well.
.model swhs sw(ron=0.03 roff=1meg vt=0.5 vh=0.1)
.model swls sw(ron=0.02 roff=1meg vt=0.5 vh=0.1)
* Switching circuits are where a general purpose solver earns its reputation
* for not converging, and this deck took three attempts.
*
* An infinitely sharp comparator fails outright. A tanh instead fails
* differently and more interestingly: it saturates, so its derivative vanishes,
* Newton is left with no gradient to follow and the gate node runs away to a
* thousand volts. What works is a comparator that is linear across a narrow
* band and hard limited outside it, so the Jacobian is finite where it matters
* and the output cannot leave [0, 1] however badly an iteration misbehaves.
* The band is 1 mV wide, which at this ramp slope is one nanosecond.
*
* Hysteresis on the switches and Gear integration do the rest.
*
* The time step matters more than it looks. At fifty points per switching
* period this deck reported 6.4 mVpp of output ripple against 2.7 mVpp from
* the simulator in this repository; at a hundred it reports 3.9 mVpp. The
* first number was mostly discretisation, not circuit behaviour, and it would
* have been easy to publish it and invent an explanation.
.options method=gear maxord=2 reltol=1e-3 abstol=1e-10 vntol=1e-6 itl4=200
.control
tran 5e-09 1m 0.9m 1e-08
meas tran vavg AVG v(out) from=0.95m to=1m
meas tran vmax MAX v(out) from=0.95m to=1m
meas tran vmin MIN v(out) from=0.95m to=1m
quit
.endc
.end
