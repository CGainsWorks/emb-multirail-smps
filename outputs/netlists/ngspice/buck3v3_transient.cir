* Strict ngspice. Run: ngspice -b <file>
* Generated by smps.spice. Do not edit; `make demo` overwrites it.
* +3V3 synchronous buck, voltage mode, Type III compensation
Vin   vin 0 5
Rload out 0 1.1
Shs   vin sw   gate 0 swhs
Sls   sw  0    gateb 0 swls
Bgb   gateb 0 V = 1 - V(gate)
L1    sw  lx 1.5e-06
Rl1   lx  out 0.015
Cout  out cx 3.3e-05
Resr  cx  0  0.001
Cin   vin ci 1.4e-05
Rcin  ci  0  0.0015
Vramp ramp 0 PULSE(0 1 0 9.8e-07 2e-08 1n 1e-06)
Bpwm  gate 0 V = 0.5 + 0.5*tanh(2000*(V(comp) - V(ramp)))
R1    out fb 10200
Rbot  fb  0  3240
R3    out n3 115
Cf3   n3  fb 1.3e-09
Rf    comp nf 4530
Cf1   nf  fb 3.3e-09
Cf2   comp fb 7.5e-11
Bea   comp 0 V = min(max(1e5 * (0.8 - V(fb)), 0), 1)
* Separate models, because the two devices do not have the same Rds(on) and
* using one model for both was quietly putting the high side figure on the low
* side as well.
.model swhs sw(ron=0.03 roff=1meg vt=0.5 vh=0)
.model swls sw(ron=0.02 roff=1meg vt=0.5 vh=0)
* Switching circuits are where a general purpose solver earns its reputation
* for not converging, and the first attempt at this deck duly failed mid edge.
* What fixes it is giving the comparator a finite transition region instead of
* an infinitely sharp step: at this gain it is about 0.5 mV wide, which is
* under a nanosecond of ramp. Gear integration helps too, being better damped
* than trapezoidal on a stiff switching node.
*
* The switches deliberately have no hysteresis. Adding some also cures the
* convergence, but it opens a window where neither device conducts, and with
* no body diodes modelled the inductor current then drives the switch node
* through a megohm and rings. That showed up as more than twice the expected
* output ripple, which is a modelling artefact rather than a property of the
* converter.
.options method=gear maxord=2 reltol=1e-3 abstol=1e-10 vntol=1e-6 itl4=200
.control
tran 5e-09 1m 0.9m 1e-08
meas tran vavg AVG v(out) from=0.95m to=1m
meas tran vmax MAX v(out) from=0.95m to=1m
meas tran vmin MIN v(out) from=0.95m to=1m
quit
.endc
.end
