* +3V3 synchronous buck, voltage mode, Type III compensation
* Generated by smps.netlist from smps.components and smps.design.
* Runs in LTspice (File > Open this .cir) and in ngspice (ngspice -b file.cir).
.param TS=1e-06
.param VIN=5

Vin   vin 0 {VIN}
Rload out 0 1.1

* Power stage
Shs   vin sw   gate 0 SWMOD
Sls   sw  0    gateb 0 SWMOD
Bgb   gateb 0 V=1-V(gate)
L1    sw  outl 1.5e-06 Rser=0.015
Rout  outl out 1u
Cout  out cx   3.3e-05
Resr  cx  0    0.001
Cin   vin 0    1.4e-05 Rser=0.0015

* Trailing edge modulator: sawtooth from 0 to Vramp over one period
Vramp ramp 0 PULSE(0 1 0 {TS*0.98} {TS*0.02} 1n {TS})
Bpwm  gate 0 V=IF(V(comp)>V(ramp),1,0)

* Type III compensator around an ideal error amplifier
* R1 is the top divider resistor, so the divider is inside the network.
R1    out fb  10200
Rbot  fb  0   3240
R3    out n3  115
Cf3   n3  fb  1.3e-09
Rf    comp nf 4530
Cf1   nf  fb  3.3e-09
Cf2   comp fb 7.5e-11
Bea   comp 0  V=LIMIT(0.8*1e5-V(fb)*1e5, 0, 1)

.model SWMOD SW(Ron=0.03 Roff=1Meg Vt=0.5 Vh=0)
.tran 10n 2m 1.5m 20n
.end
